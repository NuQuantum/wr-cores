memory-map:
  name: xwrc_board_kasli_regs
  description: Board kasli register interface
  bus: wb-32-be
  schema-version:
    core: 2.0.0
    x-conversions: 1.0.0
    x-driver-edge: 1.0.0
    x-enums: 1.0.0
    x-fesa: 2.0.0
    x-gena: 2.0.0
    x-hdl: 1.0.0
    x-map-info: 1.0.0
    x-wbgen: 1.0.0
  x-hdl:
    iogroup: wrpc_kasli_regs
  children:
  - reg:
      name: RESET
      comment: WRPC Core Reset Register
      description: Controls the WRPC reset
      width: 32
      access: rw
      children:
      - field:
          name: WRPC_CORE
          comment: 'Write 1: assert the reset'
          description: External core reset
          preset: 1
          range: 0
  - reg:
      name: SYSTEM_CLOCK
      comment: System Clock Register
      description: Controls the system PLL reference clock input
      width: 32
      access: rw
      children:
      - field:
          name: SELECT
          comment: 'Write 1: SI549, Write 0: Bootsrap clock'
          description: system PLL clock select
          preset: 0
          range: 0
  - reg:
      name: DEBUG
      comment: General Purpose Debug Register
      description: Unsigned register for general debug access.
      width: 32
      access: rw
      type: unsigned
      preset: 0x11223344